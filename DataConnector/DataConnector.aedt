# Ansys Electronics Desktop project, version 2021.1

design TwinBuilder1 (Twin Builder)
components:
  SINE3 = SINE(AMPL=3 FREQ=0.2Hz PERIO=0 TPERIO=Tend+1)
  SINE2 = SINE(AMPL=2 FREQ=0.05Hz PERIO=0 PHASE=90deg TPERIO=Tend+1)
  SINE1 = SINE(AMPL=1 FREQ=0.1Hz PERIO=0 PHASE=45deg TPERIO=Tend+1)
  DataConnector1 = SimplorerDataConnectorModel(FromSimp3=SINE3.VAL FromSimp2=SINE2.VAL FromSimp1=SINE1.VAL ConnectionTimeout=20 IOTimeout=1 TS=1)
nets:
  net_1: SINE3.VAL
  net_3: SINE1.VAL
setups:
  TR: TransientData(40s, 1s, 1s, false, "")
reports:
  XY Plot 1: DataConnector1.ToSimp1, DataConnector1.ToSimp2 vs Time on TR : TR
